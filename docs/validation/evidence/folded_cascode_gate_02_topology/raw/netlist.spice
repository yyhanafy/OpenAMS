* OpenAMS folded-cascode OTA — flat MOS-level topology
*
* Independent assignment variables:
*   w_m1_um
*   vnb1_v
*   i_m3_a
*
* Balanced-current relationships:
*   I1 = I2 = I3/2
*   I4 = I5 = 1.5*I3
*   I6 = I7 = I8 = I9 = I10 = I11 = I3
*
* Width relationships:
*   W1 = W2
*   W4 = W5
*   W6 = W7
*   W8 = W9 = W10 = W11
*
* All M1-M11 must operate in saturation.

.param vdd=1.8
.param vss=0
.param vicm=0.9
.param c_load=10p

.param l_default_um=0.5
.param nf_default=1

* Independent assignment variables
.param w_m1_um={w_m1_um}
.param vnb1={vnb1_v}
.param i_m3_a={i_m3_a}

* Dependent bias voltages
.param vpb1={vpb1_v}
.param vpb2={vpb2_v}
.param vnb2={vnb2_v}

* Dependent and matched device widths
.param w_m2_um={w_m1_um}
.param w_m3_um={w_m3_um}

.param w_m4_um={w_m4_um}
.param w_m5_um={w_m4_um}

.param w_m6_um={w_m6_um}
.param w_m7_um={w_m6_um}

.param w_m8_um={w_m8_um}
.param w_m9_um={w_m8_um}
.param w_m10_um={w_m8_um}
.param w_m11_um={w_m8_um}

* Generated finger counts
.param nf_m1={nf_m1}
.param nf_m3={nf_m3}
.param nf_m4={nf_m4}
.param nf_m6={nf_m6}
.param nf_m8={nf_m8}
.param nf_m10={nf_m10}

* Convert micrometer parameters to SPICE dimensions
.param l_default={l_default_um}u

.param w_m1={w_m1_um}u
.param w_m2={w_m2_um}u
.param w_m3={w_m3_um}u
.param w_m4={w_m4_um}u
.param w_m5={w_m5_um}u
.param w_m6={w_m6_um}u
.param w_m7={w_m7_um}u
.param w_m8={w_m8_um}u
.param w_m9={w_m9_um}u
.param w_m10={w_m10_um}u
.param w_m11={w_m11_um}u

.subckt folded_cascode_ota vip vin vout vdd vss

* Dependent and independent bias sources
VNB1BIAS vnb1_node vss {vnb1}
VPB1BIAS vpb1_node vss {vpb1}
VPB2BIAS vpb2_node vss {vpb2}
VNB2BIAS vnb2_node vss {vnb2}

* M1-M2: NMOS differential input pair
XM1 psrc_left vip tail vss sky130_fd_pr__nfet_01v8
+ w={w_m1} l={l_default} nf={nf_m1}

XM2 psrc_right vin tail vss sky130_fd_pr__nfet_01v8
+ w={w_m2} l={l_default} nf={nf_m1}

* M3: NMOS tail-current source
XM3 tail vnb1_node vss vss sky130_fd_pr__nfet_01v8
+ w={w_m3} l={l_default} nf={nf_m3}

* M4-M5: PMOS upper current-source pair
XM4 psrc_left vpb1_node vdd vdd sky130_fd_pr__pfet_01v8
+ w={w_m4} l={l_default} nf={nf_m4}

XM5 psrc_right vpb1_node vdd vdd sky130_fd_pr__pfet_01v8
+ w={w_m5} l={l_default} nf={nf_m4}

* M6-M7: PMOS folded-cascode pair
XM6 x vpb2_node psrc_left vdd sky130_fd_pr__pfet_01v8
+ w={w_m6} l={l_default} nf={nf_m6}

XM7 vout vpb2_node psrc_right vdd sky130_fd_pr__pfet_01v8
+ w={w_m7} l={l_default} nf={nf_m6}

* M8-M9: NMOS cascode pair
XM8 x vnb2_node nsink_left vss sky130_fd_pr__nfet_01v8
+ w={w_m8} l={l_default} nf={nf_m8}

XM9 vout vnb2_node nsink_right vss sky130_fd_pr__nfet_01v8
+ w={w_m9} l={l_default} nf={nf_m8}

* M10-M11: NMOS lower current-sink pair
* Their common gate is self-biased by node x.
XM10 nsink_left x vss vss sky130_fd_pr__nfet_01v8
+ w={w_m10} l={l_default} nf={nf_m10}

XM11 nsink_right x vss vss sky130_fd_pr__nfet_01v8
+ w={w_m11} l={l_default} nf={nf_m10}

CLOAD vout vss {c_load}

.ends folded_cascode_ota
